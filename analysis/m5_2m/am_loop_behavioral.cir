M5A ideal one-pole opamp and transconductance pass plant, NOT a D45H11 RF model
Vlogic vcc 0 3.3
Vrail upstream 0 13.5
Vcommand cmd 0 SIN(1.328 0.996 800)
* 100dB DC, 1MHz unity gain; no vendor macromodel or offset/noise/temperature.
Gerror 0 internal cmd fb .001
Ropen internal 0 100meg
Copen internal 0 159.155p
Bdrive drive 0 V=min(max(v(internal),0),3.3)
* Helper8.2ohm, assumed pass beta50 ->6.1 A/V, bounded to1.3A.
Bpass upstream envelope I=min(max((v(drive)-0.65)*6.1,0),1.3)*min(max((v(upstream)-v(envelope))/0.3,0),1)
Bload envelope 0 I=0.15*min(max(v(envelope)/0.1,0),1)+0.05765*v(envelope)
Rbleed envelope 0 1k
Cout envelope 0 101n
Rfb envelope fb 40.2k
Rbottom fb 0 10k
Ccomp drive fb 4.7n
.control
set filetype=ascii
tran 0.2u 30m 20m 0.5u
wrdata analysis/m5_2m/am_loop_behavioral.dat v(cmd) v(envelope) v(drive)
quit
.endc
.end
